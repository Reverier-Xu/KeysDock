* SP16: BQ24074 TS bias compliance
* Verify datasheet recommendation: 10k from TS to VSS for NTC-disabled apps.
* Also show a divider-to-VIN configuration triggers TS fault.

.include models/custom/bq24074.lib
.include models/custom/passive.lib

VUSB vin 0 DC 5.0
XU4 vin bat sys ts_good 0 0 0 0 0 chg_good pg_good 0 BQ24074
XU5 vin bat sys ts_bad  0 0 0 0 0 chg_bad  pg_bad  0 BQ24074
XBAT bat 0 BATTERY PARAMS: V=3.5 R=0.1

* Correct NTC-disabled bias per datasheet: 10k from TS to GND
RTS_GOOD ts_good 0 10k

* Incorrect divider from VIN: TS sits at ~68% of VIN -> exceeds VCOLD (2.1 V)
R_TOP vin ts_bad 22k
R_BOT ts_bad 0 47k

.op
.dc VUSB 4.5 6.0 0.1
.print dc v(vin) v(ts_good) v(ts_bad) v(chg_good) v(chg_bad)
.end
