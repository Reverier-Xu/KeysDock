*==============================================================================
* SP03: TPS62142 Buck Converter — Actual PCB (rev 0.3.0)
* KeysDock Controller — 3.3V Regulator
*==============================================================================
* Actual PCB values:
*   VIN = +4V (from BQ24074)
*   L1 = 2.2µH (FTC252012S2R2MBCA)
*   Cout = 22µF + 2×100µF + 3×100nF ≈ 222.3µF total
*   EN = pulled up to VUSB via R11(100kΩ) — always on with USB
*   FB = R17(3kΩ) to +3.3V + internal divider (fixed 3.3V version)
*==============================================================================

.include ../../models/passive/passive.lib

*------------------------------------------------------------------------------
* TPS62142 Behavioral Model
*------------------------------------------------------------------------------
.subckt TPS62142_BEHAV VIN VOUT GND
.param Vout_nom = 3.3
.param Vdrop    = 0.2
.param Ron      = 0.1

B_mode N_REG GND V = u(V(VIN) - ({Vout_nom} + {Vdrop}))
B_vout VOUT GND V = {Vout_nom} * V(N_REG) + (V(VIN) - {Vdrop}) * (1 - V(N_REG))
Rout VOUT 0 {Ron}

.ends TPS62142_BEHAV

*------------------------------------------------------------------------------
* Circuit
*------------------------------------------------------------------------------
* Input from +4V rail
VIN N_VIN 0 DC 4.4

* TPS62142
X_BUCK N_VIN N_3V3 0 TPS62142_BEHAV

* Output capacitor bank (actual PCB):
* C6=22µF, C35=100µF, C36=100µF, C7,C8,C9=100nF each
* Total = 222.3µF (huge for a 2.5MHz buck)
* Note: 100µF caps on 3.3V rail — check inrush!
C_out1 N_3V3 0 22uF
C_out2 N_3V3 0 100uF
C_out3 N_3V3 0 100uF
C_out4 N_3V3 0 100nF
C_out5 N_3V3 0 100nF
C_out6 N_3V3 0 100nF

* System load: nominal ~200mA (ESP32-C6 + TLA2518 + 5 muxes)
I_load N_3V3 0 DC 200m

*------------------------------------------------------------------------------
* Analysis
*------------------------------------------------------------------------------
.control

echo "============================================"
echo "SP03: TPS62142 Buck (rev 0.3.0 PCB)"
echo "============================================"
echo ""
echo "Configuration:"
echo "  L1 = 2.2µH (FTC252012S2R2MBCA)"
echo "  Cout = 22µF + 2×100µF + 3×100nF ≈ 222.3µF"
echo "  EN = pulled to VUSB via 100kΩ"
echo ""

* === DC: VOUT vs VIN ===
dc VIN 2.5 5.5 0.01
echo "=== VOUT vs VIN ==="
echo "VIN      V(3V3)    Regulated?"
print V(N_VIN) V(N_3V3)

echo ""
echo "===== SP03 CONCLUSIONS ====="
echo ""
echo "1. Regulates with VIN > 3.5V (3.3V + 200mV dropout)"
echo "2. Battery min 3.0V → VOUT ≈ 2.8V (below 3.3V spec!)"
echo "3. 222.3µF total output capacitance is VERY high"
echo "   - May cause inrush issues on startup"
echo "   - But provides excellent transient response"
echo "4. TPS62142 2A rating: adequate for system load"
echo ""
echo "CRITICAL: Battery discharge below ~3.3V VBAT:"
echo "  +4V rail drops, buck goes into dropout"
echo "  +3.3V rail drops below spec → analog accuracy degraded"
echo "  Recommend: firmware cutoff at VBAT < 3.3V"
echo ""
echo "NOTE: 2×100µF caps (C35,C36) are unusually large for 0402"
echo "  Verify footprint: probably 0805 or 1206, not 0402"

.endc

.end
