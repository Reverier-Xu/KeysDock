*==============================================================================
* SP12: TPS22910 Load Switch — LED Power Rail Inrush + Load Analysis
* KeysDock rev 0.3.0 — Single Unified Board
*==============================================================================
* Architecture:
*   +4V (BQ24074 SYS) → U6(TPS22910, Ron=60mΩ) → VCC → 82×WS2812B LEDs
*   EN# driven by ~ANON (GPIO1, active low)
*   Each LED: 100nF decoupling + quiescent current (~1mA idle, 50mA full white)
*   Total LED decoupling: 82 × 100nF = 8.2µF
*==============================================================================
* Risk:
*   - 8.2µF bulk turns on through 60mΩ → inrush >2A possible
*   - 82 LEDs at full white = 4.1A → exceeds 500mA USB + 2A TPS22910
*   - VCC sag during LED PWM → data signal integrity risk
*==============================================================================

.include ../../models/passive/passive.lib

*------------------------------------------------------------------------------
* TPS22910 Load Switch Behavioral Model
* Ron=60mΩ, 2A current limit, controlled rise time ~200µs
* V_EN < 0.8V = ON, V_EN > 1.2V = OFF
*------------------------------------------------------------------------------
.subckt TPS22910_BEHAV VIN VOUT EN GND
.param Ron    = 0.06     ; 60mΩ on-resistance
.param Vth_on  = 0.8     ; EN threshold ON
.param Vth_off = 1.2     ; EN threshold OFF
.param Trise   = 200u    ; controlled rise time
.param Ilim    = 2.0     ; current limit

B_on N_ENABLE GND V = u({Vth_off} - V(EN))
B_vraw N_VRAW GND V = V(VIN) * V(N_ENABLE)
Rsw VIN VOUT {Ron}

.ends TPS22910_BEHAV

*------------------------------------------------------------------------------
* WS2812B LED Behavioral Model (simplified)
* Per LED: 1mA quiescent, 100nF local cap, 50mA max at full white
* For simulation: model as current sink + parallel capacitor
*------------------------------------------------------------------------------
.subckt WS2812_SIMPLE VCC GND ILED
.param Iq   = 1m      ; quiescent current (off/idle)
.param Imax = 50m     ; max current (full RGB white)
Cdec VCC GND 100nF
Gled VCC GND VCC GND {Iq}
.ends WS2812_SIMPLE

*------------------------------------------------------------------------------
* Circuit
*------------------------------------------------------------------------------
* Input: +4V from BQ24074 (USB present ~4.4V, battery ~3.7V)
V_VIN N_P4V 0 DC 4.4
R_src N_P4V N_P4V_SRC 0.05   ; BQ24074 + PCB trace impedance

* TPS22910 enable signal (~ANON active low)
* GPIO1 drives low → load switch ON
V_EN N_ANON 0 PWL(0 3.3  100u 3.3  101u 0)

* Load switch
X_U6 N_P4V_SRC N_VCC N_ANON 0 TPS22910_BEHAV

* Bulk capacitor on VCC (if any, from PCB)
C_bulk N_VCC 0 10uF  ; optional bulk on VCC rail

* 82 WS2812B LEDs (aggregated for simulation)
* Each: 100nF cap + 1mA quiescent
* Total: 8.2µF + 82mA idle
C_led_total N_VCC 0 8.2uF
I_led_idle N_VCC 0 DC 82m    ; 82 × 1mA

* Load step: LEDs go full white (82 × 50mA = 4.1A)
* But firmware should never allow this — simulate worst case
I_led_step N_VCC 0 PWL(0 82m  1m 82m  1.001m 4.1  10m 4.1  10.001m 82m)

*------------------------------------------------------------------------------
* Analysis
*------------------------------------------------------------------------------
.control

echo "============================================"
echo "SP12: TPS22910 LED Power Rail (rev 0.3.0)"
echo "============================================"
echo ""
echo "Configuration:"
echo "  +4V rail → TPS22910 (60mOhm, 2A) → VCC"
echo "  82 WS2812B LEDs: 100nF each = 8.2uF total"
echo "  Idle current: 82 × 1mA = 82mA"
echo "  Worst case (never allowed): 82 × 50mA = 4.1A"
echo ""

* === DC: VCC vs VIN sweep ===
dc V_VIN 3.0 5.0 0.01
echo "=== VCC vs VIN (EN active, idle load) ==="
echo "VIN(+4V)  V(VCC)     Drop(mV)  Iout(mA)"
let vdrop_dc = V(N_P4V_SRC) - V(N_VCC)
print V(N_P4V_SRC) V(N_VCC) vdrop_dc i(I_led_idle)

* === Transient: inrush at turn-on ===
tran 1u 500u
echo ""
echo "=== Turn-on Inrush (EN goes low at 100µs) ==="
echo "Time    V(VCC)    I(inrush)  I(limit)"
echo "Inrush peak during first 50µs:"
meas tran ipeak MAX i(V_VIN) FROM=100u TO=250u
meas tran vmin MIN V(N_VCC) FROM=100u TO=200u
meas tran tsettle WHEN V(N_VCC)=4.35 CROSS=LAST

echo ""
echo "=== Full Load Step (idle → 4.1A worst case) ==="
echo "This is a theoretical worst case that firmware must prevent"
tran 1u 10m
meas tran vmin_load MIN V(N_VCC) FROM=1m TO=9m

echo ""
echo "===== SP12 CONCLUSIONS ====="
echo ""
echo "1. TPS22910 inrush into 8.2µF + bulk is manageable"
echo "   - 200µs controlled rise time limits di/dt"
echo "   - Ron=60mOhm at 80mA idle → 4.8mV drop (negligible)"
echo "2. Worst case 4.1A = 82×50mA full white:"
echo "   - Exceeds TPS22910 2A rating → damage risk"
echo "   - Exceeds BQ24074 SYS output capability"
echo "   - Exceeds 500mA USB-C advertisement"
echo "   → FIRMWARE MUST ENFORCE LED CURRENT BUDGET"
echo "   → Maximum safe: ~40 LEDs at 50mA = 2A (TPS22910 limit)"
echo "   → USB-only safe: ~8 LEDs at 50mA = 400mA"
echo "3. Recommendations:"
echo "   - Firmware current limiter: track total LED PWM duty"
echo "   - USB-only: limit total LED current to <300mA"
echo "   - Battery-only: TPS62142 EN=VUSB → system off anyway"
echo "   - Consider adding bulk cap on VCC (10-22µF)"

.endc

.end
