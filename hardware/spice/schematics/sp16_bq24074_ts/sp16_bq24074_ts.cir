*==============================================================================
* SP16: BQ24074 TS Pin Voltage Compliance Check
* KeysDock rev 0.3.0
*==============================================================================
* Actual circuit:
*   BQ24074 TS pin → R16(47kΩ) → +3.3V
*   When USB present: +3.3V=3.3V, VIN=~5V
*   When USB absent: +3.3V=0V (buck disabled), charger off anyway
*
* BQ24074 datasheet TS thresholds (referenced to VIN):
*   V_TS(HOT)  = 16.4% of VIN (0.82V @ 5V)
*   V_TS(COLD) = 45.1% of VIN (2.255V @ 5V)
*   If TS < 16.4% or > 45.1% VIN: charge suspend
*   For NTC disabled: keep TS in normal range continuously
*
* Our circuit: TS = +3.3V (fixed, not VIN-referenced!)
*   At VIN=5.0V: TS/VIN = 3.3/5.0 = 66% → OUT OF NORMAL RANGE!
*   At VIN=4.75V: TS/VIN = 3.3/4.75 = 69.5% → OUT OF NORMAL RANGE!
*   TS > 45.1% VIN → BQ24074 interprets as COLD → charge suspend
*
* BUT: BQ24074 datasheet says for NTC disabled mode:
*   "Connect TS to a resistor divider from VIN to ground,
*    or tie to a fixed voltage between V_TS_HOT and V_TS_COLD"
*   Since +3.3V is not referenced to VIN, this may be problematic
*
* FIX: Change R16 to connect TS to VIN instead of +3.3V
*   Use divider: e.g. R_upper=47kΩ to VIN, R_lower=47kΩ to GND
*   TS = VIN/2 = 2.5V @ 5V = 50% → still > 45.1%!
*   Better: keep dataasheet app circuit or use R16 to GND
*==============================================================================

.include ../../models/passive/passive.lib

*------------------------------------------------------------------------------
* Circuit
*------------------------------------------------------------------------------
* USB input voltage (sweep 4.0V ~ 5.5V to cover tolerance)
V_VUSB N_VIN 0 DC 5.0

* BQ24074 internal TS pull-down (from datasheet, ~200nA)
I_ts_leak N_TS 0 DC 200n

* Actual PCB: R16 = 47kΩ from TS to +3.3V
* But +3.3V isn't present until the buck turns on...
* Simplified: +3.3V present when USB present
V_V33 N_3V3 0 DC 3.3
R16_actual N_TS N_3V3 47k

* Monitor TS voltage ratio
B_ts_ratio N_TS_RATIO 0 V = V(N_TS) / V(N_VIN) * 100

*------------------------------------------------------------------------------
* Alternative 1: R16 to GND (NTC disabled, forced normal)
*------------------------------------------------------------------------------
R16_alt1 N_TS_GND 0 47k
B_ts_ratio_alt1 N_TS_RATIO_GND 0 V = V(N_TS_GND) / V(N_VIN) * 100

*------------------------------------------------------------------------------
* Alternative 2: Divider from VIN (standard NTC-disable circuit)
* R_upper = 47k to VIN, R_lower = 47k to GND → TS = VIN/2
*------------------------------------------------------------------------------
R16_upper N_VIN N_TS_DIV 47k
R16_lower N_TS_DIV 0 47k
B_ts_ratio_alt2 N_TS_RATIO_DIV 0 V = V(N_TS_DIV) / V(N_VIN) * 100

*------------------------------------------------------------------------------
* Analysis
*------------------------------------------------------------------------------
.control

echo "============================================"
echo "SP16: BQ24074 TS Pin Compliance (rev 0.3.0)"
echo "============================================"
echo ""
echo "BQ24074 TS thresholds (from datasheet):"
echo "  V_TS_HOT  = 16.4% VIN"
echo "  V_TS_COLD = 45.1% VIN"
echo "  NORMAL: 16.4% < TS/VIN < 45.1%"
echo "  OUTSIDE: charge suspended"
echo ""
echo "Actual PCB: TS → 47kΩ → +3.3V (not VIN-referenced!)"
echo ""

* === DC sweep VIN 4.0V → 5.5V ===
dc V_VUSB 4.0 5.5 0.01

echo "=== Actual circuit (TS→+3.3V) ==="
echo "VIN     TS(V)    TS/VIN(%)  Status"
print V(N_VIN) V(N_TS) V(N_TS_RATIO)

echo ""
echo "=== Alternative 1: TS→GND (47kΩ) ==="
echo "VIN     TS(V)    TS/VIN(%)"
print V(N_VIN) V(N_TS_GND) V(N_TS_RATIO_GND)

echo ""
echo "=== Alternative 2: Divider VIN/2 ==="
echo "VIN     TS(V)    TS/VIN(%)"
print V(N_VIN) V(N_TS_DIV) V(N_TS_RATIO_DIV)

echo ""
echo "===== SP16 CONCLUSIONS ====="
echo ""
echo "CRITICAL FINDING:"
echo "  Actual PCB: TS=3.3V fixed, not VIN-referenced"
echo "  At VIN=5.0V: TS/VIN = 66% → well above 45.1% COLD threshold"
echo "  → BQ24074 likely interprets this as COLD → charge suspended"
echo ""
echo "BUT: two mitigating factors:"
echo "  1. BQ24074 may have TS=float tolerance for NTC-disabled mode"
echo "     - Check datasheet: some have 'TS = VIN' as 'no NTC' mode"
echo "  2. TS is referenced to internal VIN divider, not external voltage"
echo "     - The IC has internal VREF for TS thresholds"
echo ""
echo "RECOMMENDATION:"
echo "  - Verify BQ24074 datasheet section on TS pin"
echo "  - If TS=3.3V is outside compliance:"
echo "    Option A: R16 to GND (TS=0% → HOT, may also suspend)"
echo "    Option B: Use standard NTC-disable divider from VIN"
echo "    Option C: Float TS (if BQ24074 supports NTC float=disable)"
echo ""
echo "NOTE: +3.3V comes from TPS62142, which itself is enabled by VUSB."
echo "  On battery alone: +3.3V=0 → TS=0 → charger off (acceptable)."

.endc

.end
