*==============================================================================
* SP02: BQ24074 Charger Power Path — Actual PCB (rev 0.3.0)
* KeysDock Controller
*==============================================================================
* Actual PCB values:
*   ISET = 1.10kΩ → ICHG ≈ K_ISET / 1.10kΩ ≈ 809 mA
*   TS = 47kΩ to +3.3V (NTC disabled)
*   VOUT = +4V rail (system power path output)
*   C_out = 10µF + 4.7µF + 10µF (C10, C13, C16)
*   USB CC = 100Ω (500mA advertisement)
*   D1 = SM4007PL reverse-polarity on VBUS path
*==============================================================================

.include ../../models/passive/passive.lib

*------------------------------------------------------------------------------
* BQ24074 VOUT Model (simplified behavioral)
* When VUSB > 4.35V (UVLO): VOUT regulated to ~4.4V
* When VUSB absent: VOUT = VBAT - Vdrop (~50mV pass-through)
*------------------------------------------------------------------------------
.subckt BQ24074_VOUT VUSB VBAT VOUT GND
.param V_reg  = 4.4
.param V_uvlo = 4.35
.param V_drop = 0.05
.param Ron    = 0.25

B_mode N_MODE GND V = u(V(VUSB) - {V_uvlo})
B_vout VOUT GND V = {V_reg} * V(N_MODE) + (V(VBAT) - {V_drop}) * (1 - V(N_MODE))
Rout VOUT 0 {Ron}

.ends BQ24074_VOUT

*------------------------------------------------------------------------------
* Circuit
*------------------------------------------------------------------------------
* USB source (nominal 5V, with cable drop)
V_VUSB N_USB 0 DC 5.0
R_cable N_USB VBUS_NET 0.15    ; USB cable + connector

* Series diode D1 (SM4007PL) — ~0.7V Vf at low current
D1 VBUS_NET N_VIN_D D_SM4007
.model D_SM4007 D (Is=5e-7 Rs=0.05 N=1.5 Cjo=15pF)

* Battery (Li-Ion 3.7V nominal)
V_BAT N_VBAT 0 DC 3.7
R_bat_int N_VBAT N_VBAT_INT 0.15  ; internal resistance

* BQ24074
XBQ N_VIN_D N_VBAT_INT P4V 0 BQ24074_VOUT

* Output capacitance (C10=10uF, C13=4.7uF, C16=10uF = 24.7µF total)
C_bulk P4V 0 24.7uF

* Load on +4V rail (TPS62142 buck + system)
* Nominal ~200mA, peak ~500mA
R_load P4V 0 22    ; 200mA @ 4.4V

* VBAT bypass: C14=4.7µF (from schematic)
C_bat N_VBAT_INT 0 4.7uF

*------------------------------------------------------------------------------
* Analysis
*------------------------------------------------------------------------------
.control

echo "============================================"
echo "SP02: BQ24074 Power Path (rev 0.3.0 PCB)"
echo "============================================"
echo ""
echo "Configuration:"
echo "  ISET = 1.10kΩ → ICHG ≈ 809 mA"
echo "  TS = 47kΩ to +3.3V (NTC disabled)"
echo "  Cout on +4V: 24.7µF total (C10+C13+C16)"
echo "  D1 = SM4007PL (Vf≈0.5V @ low current)"
echo "  USB CC = 100Ω → 500mA advertisement"
echo ""

* === DC: VOUT vs VUSB (battery=3.7V) ===
dc V_VUSB 0 5.5 0.01
echo "=== VOUT vs VUSB (VBAT=3.7V) ==="
echo "VUSB    V(IN_after_diode)  V(+4V)    Mode"
let v_in_d = V(N_VIN_D)
print V(N_USB) v_in_d V(P4V)

* === DC: VOUT vs VBAT (no USB) ===
V_VUSB_t2 N_USB 0 DC 0
dc V_BAT 3.0 4.2 0.01
echo ""
echo "=== VOUT vs VBAT (no USB) ==="
echo "VBAT     V(+4V)    Dropout"
let vdrop = V(N_VBAT_INT) - V(P4V)
print V(N_VBAT) V(P4V) vdrop

echo ""
echo "===== SP02 CONCLUSIONS ====="
echo ""
echo "1. +4V rail = 4.4V with USB, 3.0-4.2V on battery"
echo "2. D1 drops ~0.5V → BQ24074 VIN ≈ 4.5V from 5V USB"
echo "3. Still above 4.35V UVLO → regulation maintained"
echo "4. 24.7µF output cap provides good transient response"
echo "5. ICHG=809mA: adequate for 500mA USB + 200mA system"
echo ""
echo "ISSUES:"
echo "  - 100Ω CC resistors (not 5.1kΩ) advertise only 500mA"
echo "  - If system draws >300mA, battery may not charge on USB"
echo "  - Recommend 5.1kΩ for 1.5A advertisement on USB-C"

.endc

.end
